KERO E192 RC-coded hello world - TI family macro transient
.include "tlv9042.lib"
Vbat VBAT 0 PWL(0 0 0.001 3)
Cdec VBAT 0 300n
RST01T ST11_OUT ST01_TIMING 6980000
CST01 ST01_TIMING VBAT 4.7e-08 IC=0
RST01V VBAT ST01_TH 2130000
RST01G ST01_TH 0 117000
RST01F ST01_OUT ST01_TH 1050000
XST01 ST01_TH ST01_TIMING VBAT 0 ST01_OUT TLV9042
RSUMST01 ST01_OUT SUM 1000000
RST02T ST01_OUT ST02_TIMING 1650000
CST02 ST02_TIMING 0 4.7e-08 IC=0
RST02V VBAT ST02_TH 365000
RST02G ST02_TH 0 412000
RST02F ST02_OUT ST02_TH 208000
XST02 ST02_TH ST02_TIMING VBAT 0 ST02_OUT TLV9042
RSUMST02 ST02_OUT SUM 1000000
RST03T ST02_OUT ST03_TIMING 3520000
CST03 ST03_TIMING VBAT 4.7e-08 IC=0
RST03V VBAT ST03_TH 182000
RST03G ST03_TH 0 665000
RST03F ST03_OUT ST03_TH 332000
XST03 ST03_TH ST03_TIMING VBAT 0 ST03_OUT TLV9042
RSUMST03 ST03_OUT SUM 1000000
RST04T ST03_OUT ST04_TIMING 1470000
CST04 ST04_TIMING 0 4.7e-08 IC=0
RST04V VBAT ST04_TH 427000
RST04G ST04_TH 0 340000
RST04F ST04_OUT ST04_TH 213000
XST04 ST04_TH ST04_TIMING VBAT 0 ST04_OUT TLV9042
RSUMST04 ST04_OUT SUM 1000000
RST05T ST04_OUT ST05_TIMING 2430000
CST05 ST05_TIMING VBAT 4.7e-08 IC=0
RST05V VBAT ST05_TH 240000
RST05G ST05_TH 0 511000
RST05F ST05_OUT ST05_TH 258000
XST05 ST05_TH ST05_TIMING VBAT 0 ST05_OUT TLV9042
RSUMST05 ST05_OUT SUM 1000000
RST06T ST05_OUT ST06_TIMING 2000000
CST06 ST06_TIMING 0 4.7e-08 IC=0
RST06V VBAT ST06_TH 291000
RST06G ST06_TH 0 459000
RST06F ST06_OUT ST06_TH 229000
XST06 ST06_TH ST06_TIMING VBAT 0 ST06_OUT TLV9042
RSUMST06 ST06_OUT SUM 1000000
RST07T ST06_OUT ST07_TIMING 2910000
CST07 ST07_TIMING VBAT 4.7e-08 IC=0
RST07V VBAT ST07_TH 208000
RST07G ST07_TH 0 583000
RST07F ST07_OUT ST07_TH 291000
XST07 ST07_TH ST07_TIMING VBAT 0 ST07_OUT TLV9042
RSUMST07 ST07_OUT SUM 1000000
RST08T ST07_OUT ST08_TIMING 2000000
CST08 ST08_TIMING 0 4.7e-08 IC=0
RST08V VBAT ST08_TH 291000
RST08G ST08_TH 0 459000
RST08F ST08_OUT ST08_TH 229000
XST08 ST08_TH ST08_TIMING VBAT 0 ST08_OUT TLV9042
RSUMST08 ST08_OUT SUM 1000000
RST09T ST08_OUT ST09_TIMING 2000000
CST09 ST09_TIMING VBAT 4.7e-08 IC=0
RST09V VBAT ST09_TH 291000
RST09G ST09_TH 0 459000
RST09F ST09_OUT ST09_TH 229000
XST09 ST09_TH ST09_TIMING VBAT 0 ST09_OUT TLV9042
RSUMST09 ST09_OUT SUM 1000000
RST10T ST09_OUT ST10_TIMING 2430000
CST10 ST10_TIMING 0 4.7e-08 IC=0
RST10V VBAT ST10_TH 240000
RST10G ST10_TH 0 511000
RST10F ST10_OUT ST10_TH 258000
XST10 ST10_TH ST10_TIMING VBAT 0 ST10_OUT TLV9042
RSUMST10 ST10_OUT SUM 1000000
RST11T ST10_OUT ST11_TIMING 1370000
CST11 ST11_TIMING VBAT 4.7e-08 IC=0
RST11V VBAT ST11_TH 470000
RST11G ST11_TH 0 274000
RST11F ST11_OUT ST11_TH 237000
XST11 ST11_TH ST11_TIMING VBAT 0 ST11_OUT TLV9042
RSUMST11 ST11_OUT SUM 1000000
RmidV VBAT MID 100000
RmidG MID 0 100000
XDEC SUM MID VBAT 0 OUT TLV9042
RledR OUT RED_A 15k
Dred RED_A 0 LEDRMOD
RledG VBAT GREEN_A 15k
Dgreen GREEN_A OUT LEDGMOD
.model LEDRMOD D(IS=7.6e-20 N=2 RS=10)
.model LEDGMOD D(IS=1.58e-21 N=2 RS=10)
.options TIMEINT METHOD=GEAR RELTOL=1e-4 ABSTOL=1e-10
.TRAN 0.0005 12 0 0.0005 UIC
.PRINT TRAN FORMAT=CSV V(VBAT) V(OUT) V(SUM) V(MID) I(Vbat) V(ST01_OUT) V(ST02_OUT) V(ST03_OUT) V(ST04_OUT) V(ST05_OUT) V(ST06_OUT) V(ST07_OUT) V(ST08_OUT) V(ST09_OUT) V(ST10_OUT) V(ST11_OUT)
.END
