KERO corrected native encoder instrumented power accounting
.include "tlv9042.lib"
Vbat VBAT 0 PWL(0 0 .001 3)
VS_U1A_P ST01_TH U1A_P 0
VS_U1A_M ST01_TIMING U1A_M 0
VS_U1A_V VBAT U1A_V 0
VS_U1A_G 0 U1A_G 0
VS_U1A_O ST01_OUT U1A_O 0
XU1A U1A_P U1A_M U1A_V U1A_G U1A_O TLV9042
VS_U1B_P ST02_TH U1B_P 0
VS_U1B_M ST02_TIMING U1B_M 0
VS_U1B_V VBAT U1B_V 0
VS_U1B_G 0 U1B_G 0
VS_U1B_O ST02_OUT U1B_O 0
XU1B U1B_P U1B_M U1B_V U1B_G U1B_O TLV9042
VS_U1C_P ST03_TH U1C_P 0
VS_U1C_M ST03_TIMING U1C_M 0
VS_U1C_V VBAT U1C_V 0
VS_U1C_G 0 U1C_G 0
VS_U1C_O ST03_OUT U1C_O 0
XU1C U1C_P U1C_M U1C_V U1C_G U1C_O TLV9042
VS_U1D_P ST04_TH U1D_P 0
VS_U1D_M ST04_TIMING U1D_M 0
VS_U1D_V VBAT U1D_V 0
VS_U1D_G 0 U1D_G 0
VS_U1D_O ST04_OUT U1D_O 0
XU1D U1D_P U1D_M U1D_V U1D_G U1D_O TLV9042
VS_U2A_P ST05_TH U2A_P 0
VS_U2A_M ST05_TIMING U2A_M 0
VS_U2A_V VBAT U2A_V 0
VS_U2A_G 0 U2A_G 0
VS_U2A_O ST05_OUT U2A_O 0
XU2A U2A_P U2A_M U2A_V U2A_G U2A_O TLV9042
VS_U2B_P ST06_TH U2B_P 0
VS_U2B_M ST06_TIMING U2B_M 0
VS_U2B_V VBAT U2B_V 0
VS_U2B_G 0 U2B_G 0
VS_U2B_O ST06_OUT U2B_O 0
XU2B U2B_P U2B_M U2B_V U2B_G U2B_O TLV9042
VS_U2C_P ST07_TH U2C_P 0
VS_U2C_M ST07_TIMING U2C_M 0
VS_U2C_V VBAT U2C_V 0
VS_U2C_G 0 U2C_G 0
VS_U2C_O ST07_OUT U2C_O 0
XU2C U2C_P U2C_M U2C_V U2C_G U2C_O TLV9042
VS_U2D_P ST08_TH U2D_P 0
VS_U2D_M ST08_TIMING U2D_M 0
VS_U2D_V VBAT U2D_V 0
VS_U2D_G 0 U2D_G 0
VS_U2D_O ST08_OUT U2D_O 0
XU2D U2D_P U2D_M U2D_V U2D_G U2D_O TLV9042
VS_U3A_P ST09_TH U3A_P 0
VS_U3A_M ST09_TIMING U3A_M 0
VS_U3A_V VBAT U3A_V 0
VS_U3A_G 0 U3A_G 0
VS_U3A_O ST09_OUT U3A_O 0
XU3A U3A_P U3A_M U3A_V U3A_G U3A_O TLV9042
VS_U3B_P ST10_TH U3B_P 0
VS_U3B_M ST10_TIMING U3B_M 0
VS_U3B_V VBAT U3B_V 0
VS_U3B_G 0 U3B_G 0
VS_U3B_O ST10_OUT U3B_O 0
XU3B U3B_P U3B_M U3B_V U3B_G U3B_O TLV9042
VS_U3C_P ST11_TH U3C_P 0
VS_U3C_M ST11_TIMING U3C_M 0
VS_U3C_V VBAT U3C_V 0
VS_U3C_G 0 U3C_G 0
VS_U3C_O ST11_OUT U3C_O 0
XU3C U3C_P U3C_M U3C_V U3C_G U3C_O TLV9042
VS_U3D_P MAJORITY_SUM U3D_P 0
VS_U3D_M MIDREF U3D_M 0
VS_U3D_V VBAT U3D_V 0
VS_U3D_G 0 U3D_G 0
VS_U3D_O ENCODED_OUT U3D_O 0
XU3D U3D_P U3D_M U3D_V U3D_G U3D_O TLV9042
R1 ST11_OUT ST01_TIMING 6980000
R2 VBAT ST01_TH 2130000
R3 ST01_TH ST01_OUT 1050000
R4 ST01_TH 0 117000
C1 ST01_TIMING VBAT 4.7e-08 IC=0
R5 ST01_OUT ST02_TIMING 1650000
R6 VBAT ST02_TH 365000
R7 ST02_TH ST02_OUT 208000
R8 ST02_TH 0 412000
C2 ST02_TIMING 0 4.7e-08 IC=0
R9 ST02_OUT ST03_TIMING 3520000
R10 VBAT ST03_TH 182000
R11 ST03_TH ST03_OUT 332000
R12 ST03_TH 0 665000
C3 ST03_TIMING VBAT 4.7e-08 IC=0
R13 ST03_OUT ST04_TIMING 1470000
R14 VBAT ST04_TH 427000
R15 ST04_TH ST04_OUT 213000
R16 ST04_TH 0 340000
C4 ST04_TIMING 0 4.7e-08 IC=0
R17 ST04_OUT ST05_TIMING 2430000
R18 VBAT ST05_TH 240000
R19 ST05_TH ST05_OUT 258000
R20 ST05_TH 0 511000
C5 ST05_TIMING VBAT 4.7e-08 IC=0
R21 ST05_OUT ST06_TIMING 2000000
R22 VBAT ST06_TH 291000
R23 ST06_TH ST06_OUT 229000
R24 ST06_TH 0 459000
C6 ST06_TIMING 0 4.7e-08 IC=0
R25 ST06_OUT ST07_TIMING 2910000
R26 VBAT ST07_TH 208000
R27 ST07_TH ST07_OUT 291000
R28 ST07_TH 0 583000
C7 ST07_TIMING VBAT 4.7e-08 IC=0
R29 ST07_OUT ST08_TIMING 2000000
R30 VBAT ST08_TH 291000
R31 ST08_TH ST08_OUT 229000
R32 ST08_TH 0 459000
C8 ST08_TIMING 0 4.7e-08 IC=0
R33 ST08_OUT ST09_TIMING 2000000
R34 VBAT ST09_TH 291000
R35 ST09_TH ST09_OUT 229000
R36 ST09_TH 0 459000
C9 ST09_TIMING VBAT 4.7e-08 IC=0
R37 ST09_OUT ST10_TIMING 2430000
R38 VBAT ST10_TH 240000
R39 ST10_TH ST10_OUT 258000
R40 ST10_TH 0 511000
C10 ST10_TIMING 0 4.7e-08 IC=0
R41 ST10_OUT ST11_TIMING 1370000
R42 VBAT ST11_TH 470000
R43 ST11_TH ST11_OUT 237000
R44 ST11_TH 0 274000
C11 ST11_TIMING VBAT 4.7e-08 IC=0
R45 ST01_OUT MAJORITY_SUM 1000000
R46 ST02_OUT MAJORITY_SUM 1000000
R47 ST03_OUT MAJORITY_SUM 1000000
R48 ST04_OUT MAJORITY_SUM 1000000
R49 ST05_OUT MAJORITY_SUM 1000000
R50 ST06_OUT MAJORITY_SUM 1000000
R51 ST07_OUT MAJORITY_SUM 1000000
R52 ST08_OUT MAJORITY_SUM 1000000
R53 ST09_OUT MAJORITY_SUM 1000000
R54 ST10_OUT MAJORITY_SUM 1000000
R55 ST11_OUT MAJORITY_SUM 1000000
R56 VBAT MIDREF 100000
R57 MIDREF 0 100000
R58 ENCODED_OUT RED_A 15000
R59 VBAT GREEN_A 15000
D1 RED_A 0 REDMODEL
D2 GREEN_A ENCODED_OUT GREENMODEL
C12 VBAT 0 1e-07 IC=0
C13 VBAT 0 1e-07 IC=0
C14 VBAT 0 1e-07 IC=0
.model REDMODEL D(IS=7.6e-20 N=2 RS=10)
.model GREENMODEL D(IS=1.58e-21 N=2 RS=10)
.options TIMEINT METHOD=GEAR RELTOL=1e-4 ABSTOL=1e-10
.TRAN .0005 12 0 .0005 UIC
.PRINT TRAN FORMAT=CSV V(VBAT) V(ENCODED_OUT) V(MAJORITY_SUM) V(MIDREF) I(Vbat) V(GREEN_A) V(RED_A) V(ST01_OUT) V(ST01_TH) V(ST01_TIMING) V(ST02_OUT) V(ST02_TH) V(ST02_TIMING) V(ST03_OUT) V(ST03_TH) V(ST03_TIMING) V(ST04_OUT) V(ST04_TH) V(ST04_TIMING) V(ST05_OUT) V(ST05_TH) V(ST05_TIMING) V(ST06_OUT) V(ST06_TH) V(ST06_TIMING) V(ST07_OUT) V(ST07_TH) V(ST07_TIMING) V(ST08_OUT) V(ST08_TH) V(ST08_TIMING) V(ST09_OUT) V(ST09_TH) V(ST09_TIMING) V(ST10_OUT) V(ST10_TH) V(ST10_TIMING) V(ST11_OUT) V(ST11_TH) V(ST11_TIMING) I(VS_U1A_P) I(VS_U1A_M) I(VS_U1A_V) I(VS_U1A_G) I(VS_U1A_O) I(VS_U1B_P) I(VS_U1B_M) I(VS_U1B_V) I(VS_U1B_G) I(VS_U1B_O) I(VS_U1C_P) I(VS_U1C_M) I(VS_U1C_V) I(VS_U1C_G) I(VS_U1C_O) I(VS_U1D_P) I(VS_U1D_M) I(VS_U1D_V) I(VS_U1D_G) I(VS_U1D_O) I(VS_U2A_P) I(VS_U2A_M) I(VS_U2A_V) I(VS_U2A_G) I(VS_U2A_O) I(VS_U2B_P) I(VS_U2B_M) I(VS_U2B_V) I(VS_U2B_G) I(VS_U2B_O) I(VS_U2C_P) I(VS_U2C_M) I(VS_U2C_V) I(VS_U2C_G) I(VS_U2C_O) I(VS_U2D_P) I(VS_U2D_M) I(VS_U2D_V) I(VS_U2D_G) I(VS_U2D_O) I(VS_U3A_P) I(VS_U3A_M) I(VS_U3A_V) I(VS_U3A_G) I(VS_U3A_O) I(VS_U3B_P) I(VS_U3B_M) I(VS_U3B_V) I(VS_U3B_G) I(VS_U3B_O) I(VS_U3C_P) I(VS_U3C_M) I(VS_U3C_V) I(VS_U3C_G) I(VS_U3C_O) I(VS_U3D_P) I(VS_U3D_M) I(VS_U3D_V) I(VS_U3D_G) I(VS_U3D_O) I(C1) I(C2) I(C3) I(C4) I(C5) I(C6) I(C7) I(C8) I(C9) I(C10) I(C11) I(D1) I(D2) I(C12) I(C13) I(C14)
.END
